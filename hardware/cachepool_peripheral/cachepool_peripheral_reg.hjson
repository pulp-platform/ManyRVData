// Copyright 2020 ETH Zurich and University of Bologna.
// Solderpad Hardware License, Version 0.51, see LICENSE for details.
// SPDX-License-Identifier: SHL-0.51
// Licensed under Solderpad Hardware License, Version 0.51, see LICENSE for details.
{
    param_list: [
        { name: "NumTileSelRegs",
        desc: "Number of 32-bit tile-select registers. Default 2 covers up to 64 tiles (16 groups x 4 tiles).",
        type: "int",
        default: "2"
        },
        { name: "NumLp1CmoRegs",
        desc: '''Number of per-core LP1 (private-L1) CMO register slots -- one per core /
                 per private L1.  Core `cid` uses slot `cid`.  Default 64 covers every
                 currently-built config (2g/4g full = 32 cores; 2g/4g/16g tiny up to
                 64 cores).  Bump to 256 for full 16g (256 cores).''',
        type: "int",
        default: "64"
        },
    ],
    name: "cachepool_peripheral",
    clock_primary: "clk_i",
    bus_interfaces: [
        { protocol: "reg_iface", direction: "device"}
    ]
    regwidth: 32,
    registers: [
    {
        name: "HW_BARRIER",
        desc: '''Hardware barrier register. Loads to this register will block until all cores have
        performed the load. At this stage we know that they reached the same point in the control flow,
        i.e., the cores are synchronized.'''
        swaccess: "ro",
        hwaccess: "hrw",
        hwext: "true",
        fields: [{
            bits: "31:0",
            name: "HW_BARRIER",
            desc: "Hardware barrier register."
        }]
    },
    {
        name: "ICACHE_PREFETCH_ENABLE",
        desc: '''Controls prefetching of the instruction cache.'''
        swaccess: "wo",
        hwaccess: "hro",
        resval: "1",
        fields: [{
            bits: "0:0",
            name: "ICACHE_PREFETCH_ENABLE",
            desc: "Hardware barrier register."
        }]
    },
    {
        name: "SPATZ_STATUS",
        desc: '''Sets the status of the Spatz cluster.'''
        swaccess: "wo",
        hwaccess: "hro",
        fields: [{
            bits: "0:0",
            resval: "0",
            name: "SPATZ_CLUSTER_PROBE",
            desc: "Indicates the cluster is computing a kernel."
        }]
    },
    {
        name: "SPATZ_CYCLE",
        desc: '''Store cycle counts of kernels'''
        swaccess: "rw",
        hwaccess: "hro",
        resval: "0",
        fields: [{
            bits: "31:0",
            name: "SPATZ_CYC",
            desc: "Store cycle counts of kernels."
        }]
    },
    {
        name: "CLUSTER_BOOT_CONTROL",
        desc: '''Controls the cluster boot process.'''
        swaccess: "rw",
        hwaccess: "hro",
        resval: "0",
        fields: [{
            bits: "31:0",
            name: "ENTRY_POINT",
            desc: "Post-bootstrapping entry point."
        }]
    },
    {
        name: "CLUSTER_EOC_EXIT",
        desc: '''End of computation and exit status register'''
        swaccess: "rw",
        hwaccess: "hro",
        resval: "0",
        fields: [{
            bits: "3:0",
            name: "EOC_EXIT",
            desc: "Indicates the end of computation and exit status."
        }]
    },
    {
        name: "CFG_L1D_SPM",
        desc: '''Controls the configurations of L1 DCache SPM size.'''
        // hwext: "true",
        // hwqe: "true",
        swaccess: "rw",
        hwaccess: "hro",
        resval: "32",
        fields: [{
            bits: "9:0",
            name: "SPM_SIZE",
            desc: '''Size of SPM region (cache line format).'''
        }]
    },
    {
        name: "CFG_L1D_INSN",
        desc: '''Controls the L1 DCache flushing and invalidation.'''
        // hwext: "true",
        // hwqe: "true",
        swaccess: "rw",
        hwaccess: "hro",
        resval: "0",
        fields: [{
            bits: "1:0",
            name: "INSN",
            desc: "Flush or invalide the cache region."
        }]
    },
    {
        multireg: {
            name: "CFG_L1D_TILE_SEL",
            desc: '''One-hot tile selection mask for private-partition flush.
                     Each 32-bit register covers 32 tiles: register 0 → tiles 0-31,
                     register 1 → tiles 32-63.  Only used when CFG_L1D_INSN == 2'b00.'''
            swaccess: "rw",
            hwaccess: "hro",
            count: "NumTileSelRegs",
            cname: "cfg_l1d_tile_sel",
            compact: "false",
            resval: "0",
            fields: [{
                bits: "31:0",
                name: "TILE",
                desc: "Tile select bits for this 32-tile bank."
            }]
        }
    },
    {
        name: "L1D_SPM_COMMIT",
        desc: '''Controls the L1 DCache flushing and invalidation.'''
        // hwext: "true",
        // hwqe: "true",
        swaccess: "rw",
        hwaccess: "hrw",
        resval: "1",
        fields: [{
            bits: "0",
            name: "COMMIT",
            desc: "Commit the configurations for spm size."
        }]
    },
    {
        name: "L1D_INSN_COMMIT",
        desc: '''Controls the L1 DCache flushing and invalidation.'''
        // hwext: "true",
        // hwqe: "true",
        swaccess: "rw",
        hwaccess: "hrw",
        resval: "0",
        fields: [{
            bits: "0",
            name: "COMMIT",
            desc: "Commit the configurations for instructions."
        }]
    },
    {
        name: "L1D_FLUSH_STATUS",
        desc: '''Indicate the status of flushing '''
        hwext: "true",
        swaccess: "ro",
        hwaccess: "hwo",
        resval: "0",
        fields: [{
            bits: "0:0",
            name: "STATUS",
            desc: "High for running flush/invalidation; Low for idle"
        }]
    },
    {
        name: "L1D_PRIVATE",
        desc: '''Number of private banks configured per tile '''
        swaccess: "rw",
        hwaccess: "hro",
        resval: "0",
        fields: [{
            bits: "3:0",
            name: "NUMBER",
            desc: "range: 0-8"
        }]
    },
    {
        name: "L1D_ADDR",
        desc: '''Starting address of private L1D partition '''
        swaccess: "rw",
        hwaccess: "hro",
        resval: "2684354560",
        fields: [{
            bits: "31:0",
            name: "ADDR",
            desc: "Starting address of Private L1D Partition"
        }]
    },
    {
        name: "XBAR_OFFSET",
        desc: '''Cache xbar offset setting '''
        swaccess: "rw",
        hwaccess: "hro",
        resval: "0",
        fields: [{
            bits: "4:0",
            name: "OFFSET",
            desc: "range: 0-31"
        }]
    },
    {
        name: "XBAR_OFFSET_COMMIT",
        desc: '''Cache xbar offset setting '''
        swaccess: "rw",
        hwaccess: "hrw",
        resval: "0",
        fields: [{
            bits: "0",
            name: "COMMIT",
            desc: "Commit the xbar offset configurations."
        }]
    },
    // ---------------------------------------------------------------------------
    // Per-core private-L1 (LP1) CMO trigger block.
    // Vectorized per core (multireg, one slot per core) so that independent cores
    // running unrelated critical sections can issue CMOs concurrently without
    // racing on a shared trigger register.  Mirrors the CFG_L1D_INSN /
    // L1D_INSN_COMMIT / L1D_FLUSH_STATUS handshake, one instance per core.
    // Software: core `cid` writes CFG_LP1_CMO[cid] (+ CFG_LP1_CMO_ADDR[cid] for
    // INVAL_NLINE), pulses LP1_CMO_COMMIT[cid], then polls LP1_CMO_STATUS[cid].
    // ---------------------------------------------------------------------------
    {
        multireg: {
            name: "CFG_LP1_CMO",
            desc: '''Per-core LP1 CMO opcode.  0 = FENCE (write-through WBUF drain),
                     1 = INVAL_ALL, 2 = INVAL_NLINE.  Paired with CFG_LP1_CMO_ADDR
                     (INVAL_NLINE only) and triggered by LP1_CMO_COMMIT.'''
            swaccess: "rw",
            hwaccess: "hro",
            count: "NumLp1CmoRegs",
            cname: "cfg_lp1_cmo",
            compact: "false",
            resval: "0",
            fields: [{
                bits: "2:0",
                name: "OP",
                desc: "CMO opcode: 0=FENCE, 1=INVAL_ALL, 2=INVAL_NLINE."
            }]
        }
    },
    {
        multireg: {
            name: "CFG_LP1_CMO_ADDR",
            desc: '''Per-core cacheline address for LP1 INVAL_NLINE.  Ignored for
                     FENCE / INVAL_ALL.'''
            swaccess: "rw",
            hwaccess: "hro",
            count: "NumLp1CmoRegs",
            cname: "cfg_lp1_cmo_addr",
            compact: "false",
            resval: "0",
            fields: [{
                bits: "31:0",
                name: "ADDR",
                desc: "Cacheline address for INVAL_NLINE."
            }]
        }
    },
    {
        multireg: {
            name: "LP1_CMO_COMMIT",
            desc: '''Per-core LP1 CMO trigger.  SW writes 1 to commit the opcode in
                     CFG_LP1_CMO[cid]; hardware clears it to 0 once the CMO is accepted
                     (mirrors L1D_INSN_COMMIT).'''
            swaccess: "rw",
            hwaccess: "hrw",
            count: "NumLp1CmoRegs",
            cname: "lp1_cmo_commit",
            compact: "false",
            resval: "0",
            fields: [{
                bits: "0",
                name: "COMMIT",
                desc: "Commit/trigger the CMO for this core."
            }]
        }
    },
    {
        multireg: {
            name: "LP1_CMO_STATUS",
            desc: '''Per-core LP1 CMO status.  High while this core's CMO is in flight;
                     Low when idle/complete.  Polled by the runtime (like
                     L1D_FLUSH_STATUS).'''
            hwext: "true",
            swaccess: "ro",
            hwaccess: "hwo",
            count: "NumLp1CmoRegs",
            cname: "lp1_cmo_status",
            compact: "false",
            resval: "0",
            fields: [{
                bits: "0:0",
                name: "STATUS",
                desc: "High for running CMO; Low for idle/complete."
            }]
        }
    }
  ]
}
