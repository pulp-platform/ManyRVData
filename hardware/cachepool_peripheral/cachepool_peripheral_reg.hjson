// Copyright 2020 ETH Zurich and University of Bologna.
// Solderpad Hardware License, Version 0.51, see LICENSE for details.
// SPDX-License-Identifier: SHL-0.51
// Licensed under Solderpad Hardware License, Version 0.51, see LICENSE for details.
{
    param_list: [
        { name: "NumPerfCounters",
        desc: "Number of performance counters",
        type: "int",
        default: "2"
        },
    ],
    name: "cachepool_peripheral",
    clock_primary: "clk_i",
    bus_interfaces: [
        { protocol: "reg_iface", direction: "device"}
    ]
    regwidth: 32,
    registers: [
    {
        multireg: {
            name: "HART_SELECT",
            desc: '''Select from which hart in the cluster, starting from `0`,
                     the event should be counted. For each performance counter
                     the cores can be selected individually. If a hart greater
                     than the clusters total hart size is selected the selection
                     will wrap and the hart corresponding to `hart_select % total_harts_in_cluster`
                     will be selected.'''
            swaccess: "rw",
            hwaccess: "hro",
            count: "NumPerfCounters",
            cname: "hart_select",
            compact: "false",
            fields: [{
                bits: "9:0",
                name: "HART_SELECT",
                desc: "Select source of per-hart performance counter"
            }]
        }
    },
    {
        name: "CL_CLINT_SET",
        desc: '''
        Set bits in the cluster-local CLINT. Writing a 1 at location i sets the cluster-local interrupt
        of hart i, where i is relative to the first hart in the cluster, ignoring the cluster base hart ID.
        '''
        hwext: "true",
        hwqe: "true",
        swaccess: "wo",
        hwaccess: "hro",
          fields: [{
              bits: "31:0",
              name: "CL_CLINT_SET",
              desc: "Set cluster-local interrupt of hart i"
          }]
    },
    {
        name: "CL_CLINT_CLEAR",
        desc: '''
        Clear bits in the cluster-local CLINT. Writing a 1 at location i clears the cluster-local interrupt
        of hart i, where i is relative to the first hart in the cluster, ignoring the cluster base hart ID.
        '''
        hwext: "true",
        hwqe: "true",
        swaccess: "wo",
        hwaccess: "hro",
          fields: [{
              bits: "31:0",
              name: "CL_CLINT_CLEAR",
              desc: "Clear cluster-local interrupt of hart i"
          }]
    },
    {
        name: "HW_BARRIER",
        desc: '''Hardware barrier register. Loads to this register will block until all cores have
        performed the load. At this stage we know that they reached the same point in the control flow,
        i.e., the cores are synchronized.'''
        swaccess: "ro",
        hwaccess: "hrw",
        hwext: "true",
        fields: [{
            bits: "31:0",
            name: "HW_BARRIER",
            desc: "Hardware barrier register."
        }]
    },
    {
        name: "ICACHE_PREFETCH_ENABLE",
        desc: '''Controls prefetching of the instruction cache.'''
        swaccess: "wo",
        hwaccess: "hro",
        resval: "1",
        fields: [{
            bits: "0:0",
            name: "ICACHE_PREFETCH_ENABLE",
            desc: "Hardware barrier register."
        }]
    },
    {
        name: "SPATZ_STATUS",
        desc: '''Sets the status of the Spatz cluster.'''
        swaccess: "wo",
        hwaccess: "hro",
        fields: [{
            bits: "0:0",
            resval: "0",
            name: "SPATZ_CLUSTER_PROBE",
            desc: "Indicates the cluster is computing a kernel."
        }]
    },
    {
        name: "SPATZ_CYCLE",
        desc: '''Store cycle counts of kernels'''
        swaccess: "rw",
        hwaccess: "hro",
        resval: "0",
        fields: [{
            bits: "31:0",
            name: "SPATZ_CYC",
            desc: "Store cycle counts of kernels."
        }]
    },
    {
        name: "CLUSTER_BOOT_CONTROL",
        desc: '''Controls the cluster boot process.'''
        swaccess: "rw",
        hwaccess: "hro",
        resval: "0",
        fields: [{
            bits: "31:0",
            name: "ENTRY_POINT",
            desc: "Post-bootstrapping entry point."
        }]
    },
    {
        name: "CLUSTER_EOC_EXIT",
        desc: '''End of computation and exit status register'''
        swaccess: "rw",
        hwaccess: "hro",
        resval: "0",
        fields: [{
            bits: "0:0",
            name: "EOC_EXIT",
            desc: "Indicates the end of computation and exit status."
        }]
    },
    {
        name: "CFG_L1D_SPM",
        desc: '''Controls the configurations of L1 DCache SPM size.'''
        // hwext: "true",
        // hwqe: "true",
        swaccess: "rw",
        hwaccess: "hro",
        resval: "32",
        fields: [{
            bits: "9:0",
            name: "SPM_SIZE",
            desc: '''Size of SPM region (cache line format).'''
        }]
    },
    {
        name: "CFG_L1D_INSN",
        desc: '''Controls the L1 DCache flushing and invalidation.'''
        // hwext: "true",
        // hwqe: "true",
        swaccess: "rw",
        hwaccess: "hro",
        resval: "0",
        fields: [{
            bits: "1:0",
            name: "INSN",
            desc: "Flush or invalide the cache region."
        }]
    },
    {
        name: "L1D_SPM_COMMIT",
        desc: '''Controls the L1 DCache flushing and invalidation.'''
        // hwext: "true",
        // hwqe: "true",
        swaccess: "rw",
        hwaccess: "hrw",
        resval: "1",
        fields: [{
            bits: "0",
            name: "COMMIT",
            desc: "Commit the configurations for spm size."
        }]
    },
    {
        name: "L1D_INSN_COMMIT",
        desc: '''Controls the L1 DCache flushing and invalidation.'''
        // hwext: "true",
        // hwqe: "true",
        swaccess: "rw",
        hwaccess: "hrw",
        resval: "0",
        fields: [{
            bits: "0",
            name: "COMMIT",
            desc: "Commit the configurations for instructions."
        }]
    },
    {
        name: "L1D_FLUSH_STATUS",
        desc: '''Indicate the status of flushing '''
        hwext: "true",
        swaccess: "ro",
        hwaccess: "hwo",
        resval: "0",
        fields: [{
            bits: "0:0",
            name: "STATUS",
            desc: "High for running flush/invalidation; Low for idle"
        }]
    },
    {
        name: "L1D_PRIVATE",
        desc: '''Number of private banks configured per tile '''
        swaccess: "rw",
        hwaccess: "hro",
        resval: "0",
        fields: [{
            bits: "3:0",
            name: "NUMBER",
            desc: "range: 0-8"
        }]
    },
    {
        name: "L1D_ADDR",
        desc: '''Starting address of private L1D partition '''
        swaccess: "rw",
        hwaccess: "hro",
        resval: "2684354560",
        fields: [{
            bits: "31:0",
            name: "ADDR",
            desc: "Starting address of Private L1D Partition"
        }]
    },
    {
        name: "XBAR_OFFSET",
        desc: '''Cache xbar offset setting '''
        swaccess: "rw",
        hwaccess: "hro",
        resval: "0",
        fields: [{
            bits: "4:0",
            name: "OFFSET",
            desc: "range: 0-31"
        }]
    },
    {
        name: "XBAR_OFFSET_COMMIT",
        desc: '''Cache xbar offset setting '''
        swaccess: "rw",
        hwaccess: "hrw",
        resval: "0",
        fields: [{
            bits: "0",
            name: "COMMIT",
            desc: "Commit the xbar offset configurations."
        }]
    }
  ]
}
